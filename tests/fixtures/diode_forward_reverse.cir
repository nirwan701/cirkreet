.title Forward and reverse biased diodes
VPLUS vp 0 DC 5
VMINUS vm 0 DC -5
R1 vp nf 1k
D1 nf 0 DGEN
R2 vm nr 1k
D2 0 nr DGEN
.model DGEN D (IS=1e-12 N=1)
.dc VPLUS 0 5 0.1
.ac dec 20 1 100k
.end
