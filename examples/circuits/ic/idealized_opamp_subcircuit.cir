.title Nested educational op-amp macro-model example
* This is an idealized voltage-controlled-source macro-model, not an LM358 model.
.subckt OPAMP_CORE INP INM VCC VEE OUT
EGAIN NDRV 0 INP INM 10000
ROUT NDRV OUT 50
.ends OPAMP_CORE
.subckt OPAMP INP INM VCC VEE OUT
XCORE INP INM VCC VEE NDRV OPAMP_CORE
RLOADISO NDRV OUT 50
.ends OPAMP
VCC vcc 0 DC 12
VIN inp 0 DC 1 AC 0.1
RFB out inm 10k
RG inm 0 1k
RL out 0 10k
XU1 inp inm vcc 0 out OPAMP
.ac dec 40 1 1Meg
.end
