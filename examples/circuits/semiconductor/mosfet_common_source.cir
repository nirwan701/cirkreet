.title NMOS common-source amplifier with capacitive input coupling
VDD vdd 0 DC 12
VIN in 0 PULSE(0 1 0 10u 10u 500u 1m) AC 10m
CIN in gate 1u
RGT vdd gate 220k
RGB gate 0 100k
RD vdd drain 4.7k
RS source 0 1k
CS source 0 100u
M1 drain gate source source MN W=50u L=1u
.model MN NMOS (VTO=1.2 KP=200u LAMBDA=0.01 CGS=20p CGD=5p)
.circhecker OUTPUT=drain
.ac dec 30 10 100k
.tran 2u 4m
.end
