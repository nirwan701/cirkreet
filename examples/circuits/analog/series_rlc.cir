.title Series RLC resonance and damping
* Series R-L branch feeding a shunt capacitor; AC input is 1 V.
VIN in 0 DC 0 AC 1
R1 in n1 100
L1 n1 out 10m
C1 out 0 100n
.ac dec 60 100 100k
.tran 2u 4m
.end
