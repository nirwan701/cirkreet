.title Full-wave bridge rectifier with reservoir capacitor
* Simple source-resistance model; not a coupled transformer model.
VSEC drive 0 SIN(0 10 50)
RS drive a 2
D1 a vp DM
D2 0 vp DM
D3 vn a DM
D4 vn 0 DM
RLOAD vp vn 1k
CLOAD vp vn 470u IC=0
.model DM D (IS=1e-14 N=1.2)
.tran 50u 40m
.end
