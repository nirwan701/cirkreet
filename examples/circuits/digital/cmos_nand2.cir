.title CMOS two-input NAND gate transient demonstration
VDD vdd 0 DC 5
VA a 0 PULSE(0 5 0 10n 10n 4u 8u)
VB b 0 PULSE(0 5 0 10n 10n 2u 4u)
* PMOS pull-up network: parallel devices
MPA out a vdd vdd PM W=20u L=1u
MPB out b vdd vdd PM W=20u L=1u
* NMOS pull-down network: series devices
MNA out a mid 0 NM W=10u L=1u
MNB mid b 0 0 NM W=10u L=1u
CLOAD out 0 20p
.model NM NMOS (VTO=1 KP=200u LAMBDA=0.02 CGS=2p CGD=1p)
.model PM PMOS (VTO=-1 KP=100u LAMBDA=0.02 CGS=2p CGD=1p)
.tran 10n 32u
.end
