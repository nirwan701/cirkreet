.title Complementary MOS inverter transient demonstration
VDD vdd 0 DC 5
VIN in 0 PULSE(0 5 0 10n 10n 5u 10u)
MN out in 0 0 NM W=10u L=1u
MP out in vdd vdd PM W=20u L=1u
CLOAD out 0 10p
.model NM NMOS (VTO=1 KP=200u LAMBDA=0.02 CGS=2p CGD=1p)
.model PM PMOS (VTO=-1 KP=100u LAMBDA=0.02 CGS=2p CGD=1p)
.tran 20n 40u
.end
